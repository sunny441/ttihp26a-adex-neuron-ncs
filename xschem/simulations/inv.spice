** sch_path: /foss/designs/ttihp26a-adex-neuron-ncs/xschem/inv.sch
**.subckt inv VDD in out VSS
*.iopin VDD
*.ipin in
*.iopin VSS
*.opin out
XM1 out in VSS VSS sg13_lv_nmos w=1.2u l=0.28u ng=1
XM2 out in VDD VDD sg13_lv_pmos w=2.4u l=0.28u ng=1
**.ends
.end
