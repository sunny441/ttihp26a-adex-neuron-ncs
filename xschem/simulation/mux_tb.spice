** sch_path: /foss/designs/ttihp26a-adex-neuron-ncs/xschem/mux_tb.sch
**.subckt mux_tb
VDD1 VDD GND 1.2
x1 VDD GND sel selB in0 out in1 mux2I1
VIN0 in0 GND 1.0
.save i(vin0)
VIN1 in1 GND 0.5
.save i(vin1)
Vsel sel GND PULSE(0 1.2 10u 1n 1n 10u 20u)
RLOAD out GND 1G
CLOAD out GND 2p
x2 VDD sel selB GND inv
**** begin user architecture code

.lib cornerMOSlv.lib mos_tt
.lib cornerMOShv.lib mos_tt

.include mux2I1.save
.include mux_tb.save
.param temp 27

* Select toggles
VSEL sel GND PULSE(0 1.2 10u 1n 1n 10u 20u)

* Analog input 0
VIN0 in0 GND SIN(0.6 0.2 20k)

* Analog input 1
VIN1 in1 GND PWL(0u 0.2 10u 0.8 20u 0.4 30u 1.0 40u 0.5)

XMU VDD VSS sel in0 out in1 mux2I1

.control
op
save v(sel) v(in0) v(in1) v(out)
tran 1n 40u
plot v(in0) v(in1) v(out) v(sel)
write mux_tb.raw
.endc

**** end user architecture code
**.ends

* expanding   symbol:  mux2I1.sym # of pins=7
** sym_path: /foss/designs/ttihp26a-adex-neuron-ncs/xschem/mux2I1.sym
** sch_path: /foss/designs/ttihp26a-adex-neuron-ncs/xschem/mux2I1.sch
.subckt mux2I1 VDD VSS sel selbar in0 out in1
*.ipin in0
*.iopin VDD
*.iopin VSS
*.opin out
*.ipin sel
*.ipin in1
*.ipin selbar
XM2 in0 selbar out VSS sg13_hv_nmos w=8u l=0.5u ng=8 m=2
XM1 in0 sel out VDD sg13_hv_pmos w=16u l=0.5u ng=16
XM3 in1 sel out VSS sg13_hv_nmos w=8u l=0.5u ng=8 m=2
XM4 in1 selbar out VDD sg13_hv_pmos w=16u l=0.5u ng=16
.ends

* expanding   symbol:  inv.sym # of pins=4
** sym_path: /foss/designs/ttihp26a-adex-neuron-ncs/xschem/inv.sym
** sch_path: /foss/designs/ttihp26a-adex-neuron-ncs/xschem/inv.sch
.subckt inv VDD in out GND
*.ipin in
*.iopin VDD
*.iopin GND
*.opin out
XM1 out in VDD VDD sg13_hv_pmos w=1u l=0.5u ng=1
XM2 out in GND GND sg13_hv_nmos w=1u l=0.5u ng=1
.ends

.GLOBAL GND
.GLOBAL VDD
.end
