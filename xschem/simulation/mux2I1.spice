** sch_path: /foss/designs/ttihp26a-adex-neuron-ncs/xschem/mux2I1.sch
**.subckt mux2I1 VDD VSS sel selbar in0 out in1
*.ipin in0
*.iopin VDD
*.iopin VSS
*.opin out
*.ipin sel
*.ipin in1
*.ipin selbar
XM2 in0 selbar out VSS sg13_hv_nmos w=8u l=0.5u ng=8 m=2
XM1 in0 sel out VDD sg13_hv_pmos w=16u l=0.5u ng=16
XM3 in1 sel out VSS sg13_hv_nmos w=8u l=0.5u ng=8 m=2
XM4 in1 selbar out VDD sg13_hv_pmos w=16u l=0.5u ng=16
**.ends
.end
