* Extracted by KLayout with SG13G2 LVS runset on : 18/03/2026 23:16

.SUBCKT mux21 VSS SEL1 OUT IN1 VDD IN0
M$2 VSS SEL1 \$6 VSS sg13_lv_nmos L=0.15u W=1u AS=0.49p AD=0.49p PS=2.98u
+ PD=2.98u rfmode=0
M$5 OUT SEL1 IN1 VSS sg13_lv_nmos L=0.15u W=8u AS=2.24p AD=2.24p PS=13.48u
+ PD=13.48u rfmode=0
M$15 VSS \$7 \$8 VSS sg13_lv_nmos L=0.15u W=1u AS=0.49p AD=0.49p PS=2.98u
+ PD=2.98u rfmode=0
M$18 OUT \$7 IN0 VSS sg13_lv_nmos L=0.15u W=8u AS=2.24p AD=2.24p PS=13.48u
+ PD=13.48u rfmode=0
M$28 VDD SEL1 \$6 VDD sg13_lv_pmos L=0.15u W=1u AS=0.49p AD=0.49p PS=2.98u
+ PD=2.98u rfmode=0
M$31 OUT \$6 IN1 VDD sg13_lv_pmos L=0.15u W=8u AS=2.24p AD=2.24p PS=13.48u
+ PD=13.48u rfmode=0
M$41 VDD \$7 \$8 VDD sg13_lv_pmos L=0.15u W=1u AS=0.49p AD=0.49p PS=2.98u
+ PD=2.98u rfmode=0
M$44 OUT \$8 IN0 VDD sg13_lv_pmos L=0.15u W=8u AS=2.24p AD=2.24p PS=13.48u
+ PD=13.48u rfmode=0
.ENDS mux21
