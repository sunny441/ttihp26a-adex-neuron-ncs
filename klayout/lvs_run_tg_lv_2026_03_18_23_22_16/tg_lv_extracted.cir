* Extracted by KLayout with SG13G2 LVS runset on : 18/03/2026 23:22

.SUBCKT tg_lv VSS SEL OUT IN VDD
M$2 VSS SEL \$6 VSS sg13_lv_nmos L=0.15u W=1u AS=0.49p AD=0.49p PS=2.98u
+ PD=2.98u rfmode=0
M$5 OUT SEL IN VSS sg13_lv_nmos L=0.15u W=8u AS=2.24p AD=2.24p PS=13.48u
+ PD=13.48u rfmode=0
M$15 VDD SEL \$6 VDD sg13_lv_pmos L=0.15u W=1u AS=0.49p AD=0.49p PS=2.98u
+ PD=2.98u rfmode=0
M$18 OUT \$6 IN VDD sg13_lv_pmos L=0.15u W=8u AS=2.24p AD=2.24p PS=13.48u
+ PD=13.48u rfmode=0
.ENDS tg_lv
