* Extracted by KLayout with SG13G2 LVS runset on : 18/03/2026 22:29

.SUBCKT inv out in
M$1 \$2 in out \$1 sg13_hv_nmos L=0.5u W=4u AS=1.36p AD=1.36p PS=8.68u PD=8.68u
M$2 \$9 in out \$8 sg13_hv_pmos L=0.5u W=4u AS=1.36p AD=1.36p PS=8.68u PD=8.68u
R$3 \$8 \$9 ntap1 A=2.75p P=7.5u
R$4 \$1 \$2 ptap1 A=2.75p P=7.5u
.ENDS inv
